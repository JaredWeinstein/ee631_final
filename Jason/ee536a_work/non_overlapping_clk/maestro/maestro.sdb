ADE simulation setup
Run mode: Single Run, Sweeps and Corners
Tests:
  ee536a_work_non_overlapping_clk_1: ee536a_work/non_overlapping_clk/schematic, simulator spectre
