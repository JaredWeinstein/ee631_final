ADE simulation setup
Test ee536a_work_non_overlapping_clk_1: ee536a_work/non_overlapping_clk/schematic, simulator spectre
  Models: /home/jjmoya@vlab.usc.edu/ee536a/Techfile_45nm.scs
  Temperature: 27
  Analysis tran: stop=20n
  Signals: /p1e, /p1, /p2e, /p2
Run mode: Single Run, Sweeps and Corners
