ADE simulation setup
Test ee536a_work_DAC_1: ee536a_work/DAC/schematic, simulator spectre
  Models: /home/jjmoya@vlab.usc.edu/ee536a/Techfile_45nm.scs
  Variables: C = 300f; L = 45n; W = 30u
  Temperature: 27
  Stimulus a0: voltage bit rise=100p fall=100p period=5n srcType=bit data=1110
  Stimulus a0b: voltage bit rise=100p fall=100p period=5n srcType=bit data=0001
  Stimulus a1: voltage bit rise=100p fall=100p period=5n srcType=bit data=1000
  Stimulus a1b: voltage bit rise=100p fall=100p period=5n srcType=bit data=0111
  Analysis tran: stop=20n
  Signals: /a0, /a0b, /a1, /a1b, /dac_out
Run mode: Single Run, Sweeps and Corners
