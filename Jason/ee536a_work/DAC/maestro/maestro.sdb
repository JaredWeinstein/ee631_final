ADE simulation setup
Run mode: Single Run, Sweeps and Corners
Tests:
  ee536a_work_DAC_1: ee536a_work/DAC/schematic, simulator spectre
    Variables: L = 45n; W = 30u; C = 300f
