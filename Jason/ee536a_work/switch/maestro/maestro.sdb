ADE simulation setup
Run mode: Single Run, Sweeps and Corners
Tests:
  ee536a_work_switch_1: ee536a_work/switch/schematic, simulator spectre
    Variables: L = 45n; W = 45n
