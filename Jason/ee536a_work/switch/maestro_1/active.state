ADE simulation setup
Test ee536a_work_switch_1: ee536a_work/switch/schematic, simulator spectre
  Models: /home/jjmoya@vlab.usc.edu/ee536a/Techfile_45nm.scs
  Variables: L = 45n; W = 45n
  Temperature: 27
  Stimulus sin: voltage dc dc=500.0m srcType=dc
  Analysis dc: sweep W start=45n stop=1u lin=100
  Analysis tran: stop=20n
  Signals: /sin, /clk, /so
Run mode: Single Run, Sweeps and Corners
