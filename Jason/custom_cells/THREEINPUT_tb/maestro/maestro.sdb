ADE simulation setup
Run mode: Single Run, Sweeps and Corners
Tests:
  custom_cells_THREEINPUT_tb_1: custom_cells/THREEINPUT_tb/config, simulator spectre
