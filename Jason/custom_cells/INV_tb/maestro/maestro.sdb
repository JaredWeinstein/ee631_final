ADE simulation setup
Run mode: Single Run, Sweeps and Corners
Tests:
  custom_cells_INV_tb_1: custom_cells/INV_tb/config, simulator spectre
