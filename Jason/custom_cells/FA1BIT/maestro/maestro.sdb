ADE simulation setup
Run mode: Single Run, Sweeps and Corners
Tests:
  custom_cells_FA1BIT_1: custom_cells/FA1BIT/schematic, simulator spectre
