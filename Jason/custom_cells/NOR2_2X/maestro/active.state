ADE simulation setup
Test custom_cells_NOR2_1X_1: custom_cells/NOR2_1X/schematic, simulator spectre
  Models: /home/viterbi/01/ee577/CDS_GPDK45/gpdk045_v_5_0/gpdk045/../models/spectre/gpdk045.scs[mc]
  Temperature: 27
  Stimulus in_a: voltage bit rise=10p fall=10p period=1n data=0101
  Stimulus in_b: voltage bit rise=10p fall=10p period=1n data=0011
  Stimulus vdd!: voltage dc dc=1
  Analysis tran: stop=10n
  Signals: /in_a, /in_b, /out
