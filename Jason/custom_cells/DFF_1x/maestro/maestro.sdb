ADE simulation setup
Run mode: Single Run, Sweeps and Corners
Tests:
  custom_cells_DFF_1x_1: custom_cells/DFF_1x/schematic, simulator spectre
    Variables: Lndff = 45n; Lpdff = 45n; Wndff = 90n; Wpdff = 90n
