ADE simulation setup
Test custom_cells_FA1BITa_1: custom_cells/FA1BITa/schematic, simulator spectre
  Models: /home/viterbi/01/ee577/CDS_GPDK45/gpdk045_v_5_0/gpdk045/../models/spectre/gpdk045.scs[mc]
  Temperature: 27
  Stimulus vdd!: voltage dc dc=1
  Stimulus A: voltage bit rise=10ps fall=10ps period=1ns data=01010101
  Stimulus B: voltage bit rise=10ps fall=10ps period=1ns data=00110011
  Stimulus Cin: voltage bit rise=10ps fall=10ps period=1ns data=00001111
  Analysis tran: stop=10n
  Signals: /A, /B, /Cin, /Cout, /S
