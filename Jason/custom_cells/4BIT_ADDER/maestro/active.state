ADE simulation setup
Test custom_cells_4BIT_ADDER_1: custom_cells/4BIT_ADDER/schematic, simulator spectre
  Models: /home/viterbi/01/ee577/CDS_GPDK45/gpdk045_v_5_0/gpdk045/../models/spectre/gpdk045.scs[mc]
  Temperature: 27
  Stimulus A1: voltage bit rise=10ps fall=10ps period=1ns data=01
  Stimulus B1: voltage bit rise=10ps fall=10ps period=1ns data=00
  Stimulus B2: voltage bit rise=10ps fall=10ps period=1ns data=00
  Stimulus B3: voltage bit rise=10ps fall=10ps period=1ns data=00
  Stimulus B4: voltage bit rise=10ps fall=10ps period=1ns data=00
  Stimulus A4: voltage bit rise=10ps fall=10ps period=1ns data=11
  Stimulus A3: voltage bit rise=10ps fall=10ps period=1ns data=11
  Stimulus A2: voltage bit rise=10ps fall=10ps period=1ns data=11
  Stimulus cin: voltage bit rise=10ps fall=10ps period=1ns data=11
  Stimulus vdd!: voltage dc dc=1
  Analysis tran: stop=10n
  Signals: /A1, /C4
Run mode: Single Run, Sweeps and Corners
