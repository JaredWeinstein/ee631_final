ADE simulation setup
Test custom_cells_FOURINPUT_tb_1: custom_cells/FOURINPUT_tb/schematic, simulator spectre
  Models: /home/viterbi/01/ee577/CDS_GPDK45/gpdk045_v_5_0/gpdk045/../models/spectre/gpdk045.scs[mc]
  Temperature: 27
  Stimulus a4: voltage bit rise=10ps fall=10ps period=1ns data=11
  Stimulus b4: voltage bit rise=10ps fall=10ps period=1ns data=00
  Stimulus a3: voltage bit rise=10ps fall=10ps period=1ns data=11
  Stimulus b3: voltage bit rise=10ps fall=10ps period=1ns data=00
  Stimulus a2: voltage bit rise=10ps fall=10ps period=1ns data=11
  Stimulus b2: voltage bit rise=10ps fall=10ps period=1ns data=00
  Stimulus a1: voltage bit rise=10ps fall=10ps period=1ns data=01
  Stimulus b1: voltage bit rise=10ps fall=10ps period=1ns data=00
  Stimulus Cin: voltage bit rise=10ps fall=10ps period=1ns data=11
  Stimulus vdd!: voltage dc dc=1
  Analysis tran: stop=10n
  Signals: /a1_in, /c4
