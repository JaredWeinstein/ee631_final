ADE simulation setup
Test custom_cells_4BIT_CSA_1: custom_cells/4BIT_CSA/schematic, simulator spectre
  Models: /home/viterbi/01/ee577/CDS_GPDK45/gpdk045_v_5_0/gpdk045/../models/spectre/gpdk045.scs[mc]
  Temperature: 27
  Files: vectors /home/viterbi/02/jjmoya/work_gpdk045/sim_files/4bit_adder.vec
  Analysis tran: stop=10n
  Signals: /A0, /A1, /A2, /A3, /B0, /B1, /B2, /B3, /cin, /S0, /S1, /S2, /S3, /Cout
