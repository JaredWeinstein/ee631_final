ADE simulation setup
Run mode: Single Run, Sweeps and Corners
Tests:
  custom_cells_new_phase_3_top_1: custom_cells/new_phase_3_top/schematic, simulator spectre
