ADE simulation setup
Run mode: Single Run, Sweeps and Corners
Tests:
  custom_cells_TWOINPUT_tb_1: custom_cells/TWOINPUT_tb/config, simulator spectre
