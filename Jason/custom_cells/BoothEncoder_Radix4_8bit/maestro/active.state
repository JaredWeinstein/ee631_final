ADE simulation setup
Test custom_cells_BoothEncoder_Radix4_8bit_1: custom_cells/BoothEncoder_Radix4_8bit/schematic, simulator spectre
  Models: /home/viterbi/01/ee577/CDS_GPDK45/gpdk045_v_5_0/gpdk045/../models/spectre/gpdk045.scs[mc]
  Temperature: 27
Run mode: Single Run, Sweeps and Corners
