ADE simulation setup
Run mode: Single Run, Sweeps and Corners
Tests:
  custom_cells_BoothEncoder_Radix4_8bit_1: custom_cells/BoothEncoder_Radix4_8bit/schematic, simulator spectre
