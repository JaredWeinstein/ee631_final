ADE simulation setup
Run mode: Single Run, Sweeps and Corners
Tests:
  ee631_project_flash_adc_tb_1: ee631_project/flash_adc_tb/schematic, simulator spectre
    Variables: madc = 100p; fclk = 1G; L = 45n; W = 10u
