ADE simulation setup
Run mode: Single Run, Sweeps and Corners
Tests:
  custom_cells_FA1BITa_1: custom_cells/FA1BITa/schematic, simulator spectre
