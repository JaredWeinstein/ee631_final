ADE simulation setup
Run mode: Monte Carlo Sampling
Tests:
  ee536a_work:631_hw2:1: ee536a_work/631_hw2/schematic, simulator spectre
Global variables:
  L = 0.5u
  W = 110u
Monte Carlo Sampling options: mcmethod=mismatch, mcnumpoints=200
