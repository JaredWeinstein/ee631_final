ADE simulation setup
Run mode: Single Run, Sweeps and Corners
Tests:
  ee536a_work_pipeline_adc_1: ee536a_work/pipeline_adc/schematic, simulator spectre
    Variables: C_aux = 100f; Cmain = 300f; fin = 200M; idc = 100u; L = 45n; Ln = 65n; Ln_ota = 270n; Lp = 65n; Lp_l = 90n; Lp_ota = 270n; madc = 100p; vb2 = 0.32; vb3 = 0.64; vcm = 550m; vref = 550m; W = 5u; Wn_12 = 8u; Wn_34 = 120u; Wn_ota = 1u; Wp_12 = 80u; Wp_34 = 18u; Wp_idc = 7u; Wp_in = 120u; Wp_ota = 2.5u; Wp_ota_tail = 2.5u; Wp_tail = 150u; clk_period = 5n; ramp_period = 250n; vcmi = 550m; vcmo = 550m
