ADE simulation setup
Test ee536a_work_final_redesigntelescopic_1: ee536a_work/final_redesigntelescopic/schematic, simulator spectre
  Models: /home/jaredwei@vlab.usc.edu/ee536a/Techfile_45nm.scs
  Variables: Rm = 310; Cm = 600f; Ln_second = 70n; Lp_second = 90n; vb5 = 645m; Wn_second = 2.7u; Wp_second = 80u; Ln_ota = 90n; Lp_ota = 135n; Wn_ota = 40u; Wp_ota = 150u; Wtail_ota = 55u; ain = 0.5m; fin = 2M; Itail = 0.4m*1.3; Ln1 = 70n; Ln2 = 70n; Lp1 = 105n; Lp2 = 105n; Ltail = 90n; Wn1 = 20u*1.3; Wn2 = 20u*1.3; Wp1 = 120u*1.3; Wp2 = 150u*1.3; Wtail = 63u*1.3; vb1 = 650m; vb2 = 900m; vb3 = 220m; vdd = 1; vref = 500m; Ltail_ota = 90n; Rf = 500; Ri = 250
  Temperature: 27
  Analysis dc: (saves the operating point)
  Analysis ac: start=10k stop=10G
  Analysis tran: stop=1u
  Output (VF("/vout_finalp") - VF("/vout_finaln"))
  Output (VT("/vout_finalp") - VT("/vout_finaln"))
  Output (VT("/vinp") - VT("/vinn"))
  Signals: /vout_finalp, /vout_finaln, /vinp, /vinn
Run mode: Single Run, Sweeps and Corners
