ADE simulation setup
Run mode: Single Run, Sweeps and Corners
Tests:
  ee536a_work_digital_correction2_1: ee536a_work/digital_correction2/schematic, simulator spectre
    Variables: clk_period = 5n; Lndff = 45n; Lpdff = 45n; Wndff = 45n; Wpdff = 90n
    Outputs: /ph1; /ph2
