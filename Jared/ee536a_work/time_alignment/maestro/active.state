ADE simulation setup
Test ee536a_work_digital_correction2_1: ee536a_work/digital_correction2/schematic, simulator spectre
  Models: /home/jjmoya@vlab.usc.edu/ee536a/Techfile_45nm.scs
  Variables: clk_period = 5n; Lndff = 45n; Lpdff = 45n; Wndff = 45n; Wpdff = 90n
  Temperature: 27
  Stimulus d70: voltage bit val1=1.1 val0=0 rise=10p fall=10p period=1n srcType=bit data=0
  Stimulus d71: voltage bit val1=1.1 val0=0 rise=10p fall=10p period=1n srcType=bit data=0
  Stimulus d60: voltage bit val1=1.1 val0=0 rise=10p fall=10p period=1n srcType=bit data=0
  Stimulus d61: voltage bit val1=1.1 val0=0 rise=10p fall=10p period=1n srcType=bit data=0
  Stimulus d50: voltage bit val1=1.1 val0=0 rise=10p fall=10p period=1n srcType=bit data=0
  Stimulus d51: voltage bit val1=1.1 val0=0 rise=10p fall=10p period=1n srcType=bit data=0
  Stimulus d40: voltage bit val1=1.1 val0=0 rise=10p fall=10p period=1n srcType=bit data=0
  Stimulus d41: voltage bit val1=1.1 val0=0 rise=10p fall=10p period=1n srcType=bit data=0
  Stimulus d30: voltage bit val1=1.1 val0=0 rise=10p fall=10p period=1n srcType=bit data=0
  Stimulus d31: voltage bit val1=1.1 val0=0 rise=10p fall=10p period=1n srcType=bit data=0
  Stimulus d20: voltage bit val1=1.1 val0=0 rise=10p fall=10p period=1n srcType=bit data=0
  Stimulus d21: voltage bit val1=1.1 val0=0 rise=10p fall=10p period=1n srcType=bit data=0
  Stimulus d10: voltage bit val1=1.1 val0=0 rise=10p fall=10p period=1n srcType=bit data=0
  Stimulus d11: voltage bit val1=1.1 val0=0 rise=10p fall=10p period=1n srcType=bit data=0
  Analysis tran: stop=20n
  Signals: /ph1, /ph2, /clk1, /clk2, /clk3, /clk4, /clk5, /clk6, /clk7
Run mode: Single Run, Sweeps and Corners
