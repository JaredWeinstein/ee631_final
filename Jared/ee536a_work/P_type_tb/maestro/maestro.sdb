ADE simulation setup
Run mode: Single Run, Sweeps and Corners
Tests:
  ee536a_work_P_type_tb_1: ee536a_work/P_type_tb/schematic, simulator spectre
    Variables: vcm = 0.85; fin = 100K; cap = 200f
    Outputs: db20((VF("/voutp") - VF("/voutn"))); phase((VF("/voutp") - VF("/voutn"))); (VT("/vinp") - VT("/vinn"))
