ADE simulation setup
Test ee536a_work_P_type_tb_1: ee536a_work/P_type_tb/schematic, simulator spectre
  Models: /home/jaredwei@vlab.usc.edu/ee536a/Techfile_45nm.scs
  Variables: cap = 200f; fin = 100K; vcm = 0.85
  Temperature: 27
  Analysis dc: (saves the operating point)
  Analysis ac: start=1K stop=10G
  Output db20((VF("/voutp") - VF("/voutn")))
  Output (VT("/voutp") - VT("/voutn")) (unticked)
  Output phase((VF("/voutp") - VF("/voutn")))
  Output (VT("/vinp") - VT("/vinn")) (unticked)
  Signals: /voutp, /voutn, /vinp, /vinn
Run mode: Single Run, Sweeps and Corners
