ADE simulation setup
Test ee536a_work_switch_tb_1: ee536a_work/switch_tb/schematic, simulator spectre
  Models: /home/jaredwei@vlab.usc.edu/ee536a/Techfile_45nm.scs
  Variables: clk_period = 2n; fin = 111M; ramp_period = 150n; L = 45n; W = 5u
  Temperature: 27
  Analysis tran: stop=200n
  Signals: /p1 as Clk, /p2 as Clk_2, /vin as Output, /vout as Input
Run mode: Single Run, Sweeps and Corners
