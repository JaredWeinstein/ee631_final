ADE simulation setup
Run mode: Single Run, Sweeps and Corners
Tests:
  ee536a_work_switch_tb_1: ee536a_work/switch_tb/schematic, simulator spectre
    Variables: L = 45n; W = 5u; ramp_period = 150n; fin = 111M; clk_period = 2n
    Outputs: Clk; Output; Input; Clk_2
