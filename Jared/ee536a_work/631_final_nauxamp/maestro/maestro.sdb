ADE simulation setup
Run mode: Single Run, Sweeps and Corners
Tests:
  ee536a_work_631_final_nauxamp_1: ee536a_work/631_final_nauxamp/schematic, simulator spectre
    Variables: fin = 100M; Ln = 90n; Lp = 90n; vb1 = 0.5; vb2 = 0.2; vb3 = 0.65; vb4 = 0.5; vcm = 900m; Wn_12 = 1.2u; Wn_34 = 800n; Wn_56 = 55u; Wn_78 = 1.3u; Wn_9 = 3u; Wp_12 = 3.2u; Wp_34 = 4u; C_load = 1p
    Outputs: Gain; Phase
