ADE simulation setup
Test ee536a_work_631_final_nauxamp_1: ee536a_work/631_final_nauxamp/schematic, simulator spectre
  Models: /home/jaredwei@vlab.usc.edu/ee536a/Techfile_45nm.scs
  Variables: C_load = 1p; fin = 100M; Ln = 90n; Lp = 90n; vb1 = 0.5; vb2 = 0.2; vb3 = 0.65; vb4 = 0.5; vcm = 900m; Wn_12 = 1.2u; Wn_34 = 800n; Wn_56 = 55u; Wn_78 = 1.3u; Wn_9 = 3u; Wp_12 = 3.2u; Wp_34 = 4u
  Temperature: 27
  Analysis ac: start=1K stop=10G
  Analysis dc: (saves the operating point)
  Output Gain = db20((VF("/voutp") - VF("/voutn")))
  Output Phase = phase((VF("/voutp") - VF("/voutn")))
  Signals: /voutp, /voutn
Run mode: Single Run, Sweeps and Corners
