ADE simulation setup
Test ee536a_work_switch_1: ee536a_work/switch/schematic, simulator spectre
  Models: /home/jjmoya@vlab.usc.edu/ee536a/Techfile_45nm.scs
  Variables: L = 45n; W = 45n
  Temperature: 27
  Stimulus sin: voltage dc dc=500.0m srcType=dc
  Stimulus cntrl: voltage bit rise=100p fall=100p period=1n srcType=bit data=11
  Analysis dc: sweep W start=45n stop=1u lin=100 (saves the operating point)
  Analysis tran: stop=20n
  Output ron vs W = (VDC("/so") / IDC("/M0/S"))
  Signals: /sin, /so, /M0/S (terminal)
Run mode: Single Run, Sweeps and Corners
