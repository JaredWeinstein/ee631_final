ADE simulation setup
Test ee536a_work_stage_1: ee536a_work/stage/schematic, simulator spectre
  Models: /home/jaredwei@vlab.usc.edu/ee536a/Techfile_45nm.scs
  Variables: C_aux = 200f; Cmain = 500f; fin = 1M; idc = 15u; L = 45n; Ln = 65n; Ln_ota = 135n; Lp = 65n; Lp_l = 90n; Lp_ota = 135n; madc = 100p; vb2 = 0.32; vb3 = 0.64; vcm = 550m; vref = 550m; W = 5u; Wn_12 = 30u; Wn_34 = 100u; Wn_ota = 1.5u; Wp_12 = 160u; Wp_34 = 25u; Wp_idc = 4.5u; Wp_in = 95u; Wp_ota = 4u; Wp_ota_tail = 3u; Wp_tail = 225u; clk_period = 5n; ramp_period = 250n; vcmi = 550m; vcmo = 550m; m = 2; C_load = 300f
  Temperature: 27
  Analysis dc: (saves the operating point)
  Analysis tran: stop=200n
  Output (VT("/vop") - VT("/von"))
  Output (VT("/vinp") - VT("/vinn"))
  Output VT("/a1b")
  Output VT("/p2b")
  Output VT("/p2")
  Output VT("/a1")
  Output VT("/dac_outn")
  Output VT("/dac_outp")
  Output VT("/p1e")
  Output VT("/vinp_amp")
  Output VT("/vinn_amp")
  Output VT("/vop")
  Signals: /vinp, /vinn, /p2, /vinn_amp, /vinp_amp, /von, /vop, /p1e, /dac_outn, /dac_outp, /a1b, /a1
Run mode: Single Run, Sweeps and Corners
