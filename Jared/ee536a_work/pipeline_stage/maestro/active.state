ADE simulation setup
Test ee536a_work_pipeline_stage_1: ee536a_work/pipeline_stage/schematic, simulator spectre
  Models: /home/jaredwei@vlab.usc.edu/ee536a/Techfile_45nm.scs
  Variables: Lndff = 45n; Lpdff = 45n; Wndff = 45n; Wpdff = 90n; clk_period = 10n; Cmain = 250f; fin = 1M; idc = 250u; L = 45n; Ln = 65n; Ln_ota = 200n; Ln_tail = 65n; Lp = 65n; Lp_ota = 200n; madc = 100p; ramp_period = 200n; vcm = 550m; vcmi = 550m; vcmo = 550m; vref = 550m; W = 8u; Wn_12 = 10u; Wn_34 = 35u; Wn_idc = 8.3u; Wn_in = 65u; Wn_ota = 2u; Wn_tail = 100u; Wp_12 = 160u; Wp_34 = 90u; Wp_ota = 1u; Wp_ota_tail = 5u
  Temperature: 27
  Analysis dc: (saves the operating point)
  Analysis tran: stop=300n
  Output (VT("/vop") - VT("/von")) (unticked)
  Output (VT("/vinp2") - VT("/vinn2")) (unticked)
  Output VT("/vinp2") (unticked)
  Output VT("/vinn2") (unticked)
  Output VT("/a1_4d")
  Output VT("/a0_4d")
  Output VT("/a0_4")
  Output VT("/a0_2")
  Output VT("/a1_1d")
  Output VT("/a0_1d")
  Output VT("/a1_1")
  Output VT("/a0_1")
  Output VT("/p1")
  Output (VT("/a1_1") + (0.5 * (VT("/a1_2") + VT("/a0_1"))) + (0.25 * VT("/a0_2")))
  Output (VT("/vinp") - VT("/vinn"))
  Output (VT("/vinp2") - VT("/vinn"))
  Output (VT("/vinp3") - VT("/vinn"))
  Output (VT("/vinp4") - VT("/vinn"))
  Output (VT("/vinp5") - VT("/vinn"))
  Output (VT("/vinp6") - VT("/vinn"))
  Output VT("/B0")
  Output VT("/B1")
  Output VT("/B2")
  Output VT("/B3")
  Output VT("/B4")
  Output VT("/B5")
  Output VT("/B6")
  Output VT("/B7")
  Output (VT("/vinp7") - VT("/vinn"))
  Output (VT("/vinp8") - VT("/vinn"))
  Output VT("/p1e")
  Output VT("/p1eb")
  Output VT("/a1_2")
  Output VT("/a1_2d")
  Output VT("/a0_2d")
  Output VT("/a1_4")
  Signals: /vinp, /vinn, /vinp2, /a0_2, /a1_1, /p1, a1_1, /vinp3, /B0, /B1, /a1_1d, /a0_1d, /B3, /B5, /B6, /B7, /vinp4, /vinp5, /vinp6, /vinp7, /vinp8, /p1e, /p1eb, /a1_2, /a1_2d, /a0_2d, /a1_4, /a1_4d, /a0_4d, /a0_4
Run mode: Single Run, Sweeps and Corners
