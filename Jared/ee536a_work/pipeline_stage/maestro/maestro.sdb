ADE simulation setup
Run mode: Single Run, Sweeps and Corners
Tests:
  ee536a_work_pipeline_stage_1: ee536a_work/pipeline_stage/schematic, simulator spectre
    Variables: clk_period = 10n; Cmain = 250f; fin = 1M; idc = 250u; L = 45n; Ln = 65n; Ln_ota = 200n; Ln_tail = 65n; Lp = 65n; Lp_ota = 200n; madc = 100p; ramp_period = 200n; vcm = 550m; vcmi = 550m; vcmo = 550m; vref = 550m; W = 8u; Wn_12 = 10u; Wn_34 = 35u; Wn_idc = 8.3u; Wn_in = 65u; Wn_ota = 2u; Wn_tail = 100u; Wp_12 = 160u; Wp_34 = 90u; Wp_ota = 1u; Wp_ota_tail = 5u; Lndff = 45n; Lpdff = 45n; Wndff = 45n; Wpdff = 90n
    Outputs: (VT("/vop") - VT("/von")); (VT("/vinp") - VT("/vinn")); (VT("/vinp2") - VT("/vinn2")); VT("/vinp2"); VT("/vinn2"); VT("/a1_2"); VT("/a0_2"); VT("/a1_1"); VT("/a0_1"); VT("/vop"); VT("/p1"); (VT("/vinp2") - VT("/vinn")); (VT("a1_1") + (0.5 * (VT("/a1_2)) ")))); (VT("/a0_1") + (0.5 * (VT("/a0_2") + VT("/a1_1"))) + (0.25 * ("/a1_2"))); (VT("/a0_1") + (0.5 * (VT("/a0_2") + VT("/a1_1"))) + ((0.25 * VT) ("/a1_2"))); (VT("/a0_1") + (0.5 * (VT("/a0_2") + VT("/a1_1"))) + (0.25 * VT("/a1_2"))); (VT("/a1_1") + (0.5 * (VT("/a0_2") + VT("/a0_1"))) + (0.25 * VT("/a1_2"))); (VT("/a1_1") + (0.5 * (VT("/a1_2") + VT("/a0_1"))) + (0.25 * VT("/a0_2"))); VT("/vinp3"); VT("/a1_3"); VT("/a0_3"); VT("/B0"); VT("/B1"); VT("/B2"); VT("/a1_1d"); VT("/a0_1d"); VT("/a0_2d"); VT("/a1_2d"); (VT("/vinp3") - VT("/vinn")); VT("/B3"); VT("/B4"); VT("/B5"); VT("/B6"); VT("/B7"); (VT("/vinp4") - VT("/vinn")); (VT("/vin3") - VT("/vinn")); (VT("/vinp5") - VT("/vinn")); (VT("/vinp6") - VT("/vinn")); (VT("/vinp7") - VT("/vinn")); (VT("/vinp8") - VT("/vinn")); VT("/a1_3d"); VT("/p1e"); VT("/p1eb"); VT("/a0_3d"); VT("/a1_4"); VT("/a1_4d"); VT("/a0_4d"); VT("/a0_4")
