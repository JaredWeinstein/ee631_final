ADE simulation setup
Test ee536a_work_631_final_mainamp_1: ee536a_work/631_final_mainamp/schematic, simulator spectre
  Models: /home/jaredwei@vlab.usc.edu/ee536a/Techfile_45nm.scs
  Variables: R_f = 16K; Ri = 8K; idc = 50u; Ln = 60n; Lp = 60n; Lp_l = 135n; vb2 = 0.32; vb3 = 0.64; vcm = 500m; vref = 500m; Wn_12 = 8u; Wn_34 = 50u; Wp_12 = 70u; Wp_34 = 12u; Wp_idc = 10u; Wp_in = 50u; Wp_tail = 90u; vb4 = 476.7m; fin = 50M; vin = 5u; C_aux = 0.01f; Cf = 100f; Ci = 100f; R_fb = 100; C_load = 300f; Ln_ota = 270n; Lp_ota = 270n; Wn_ota = 1u; Wp_ota = 2.5u; Wp_ota_tail = 2.5u
  Temperature: 27
  Analysis dc: (saves the operating point)
  Analysis ac: start=1K stop=10G
  Analysis tran: stop=20u errpreset=moderate
  Output Gain = db20((VF("/voutp") - VF("/voutn")))
  Output Phase = phase((VF("/voutp") - VF("/voutn")))
  Output trans_in = (VT("/vinp") - VT("/vinn"))
  Output trans_out = (VT("/voutp") - VT("/voutn"))
  Output VT("/voutn") (unticked)
  Output VT("/voutp") (unticked)
  Signals: /voutp, /voutn, /vinp, /vinn
