ADE simulation setup
Run mode: Single Run, Sweeps and Corners
Tests:
  ee536a_work_stage_1: ee536a_work/stage/schematic, simulator spectre
    Variables: C_aux = 200f; Cmain = 255f; fin = 1M; idc = 250u; L = 45n; Ln = 65n; Ln_ota = 200n; Lp = 65n; Lp_l = 135n; Lp_ota = 200n; madc = 100p; vb2 = 0.32; vb3 = 0.64; vcm = 550m; vref = 550m; W = 8u; Wn_12 = 12u; Wn_34 = 35u; Wn_ota = 2.2u; Wp_12 = 170u; Wp_34 = 80u; Wp_idc = 10u; Wp_in = 85u; Wp_ota = 1u; Wp_ota_tail = 5u; Wp_tail = 70u; clk_period = 10n; ramp_period = 400n; vcmi = 550m; vcmo = 550m; m = 2; C_load = 300f; Ln_tail = 65n; Wn_idc = 8.3u; Wn_in = 55u; Wn_tail = 90u
    Outputs: VT("/vinn_amp"); nil; (VT("/vinp_amp") - VT("/vinn_amp")); (VT("/vop")); VT("/von"); VT("/vop"); VT("/vinp_amp"); VT("/p1"); VT("/p2b"); VT("/a1"); VT("/a0"); VT("/voutp_amp"); VT("/p1e"); VT("/SHn"); VT("/SHp"); VT("/dac_outn"); VT("/dac_outp"); VT("/a1b"); VT("/vinp"); (VT("/vinp") - VT("/vinn")); (VT("/vop") + VT("/von")); ((VT("/vop") + VT("/von")) / 2); VT("/p1eb")
