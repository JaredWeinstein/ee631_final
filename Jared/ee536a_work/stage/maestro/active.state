ADE simulation setup
Test ee536a_work_stage_1: ee536a_work/stage/schematic, simulator spectre
  Models: /home/jaredwei@vlab.usc.edu/ee536a/Techfile_45nm.scs
  Variables: C_aux = 200f; Cmain = 255f; fin = 1M; idc = 250u; L = 45n; Ln = 65n; Ln_ota = 200n; Lp = 65n; Lp_l = 135n; Lp_ota = 200n; madc = 100p; vb2 = 0.32; vb3 = 0.64; vcm = 550m; vref = 550m; W = 8u; Wn_12 = 12u; Wn_34 = 35u; Wn_ota = 2.2u; Wp_12 = 170u; Wp_34 = 80u; Wp_idc = 10u; Wp_in = 85u; Wp_ota = 1u; Wp_ota_tail = 5u; Wp_tail = 70u; clk_period = 10n; ramp_period = 400n; vcmi = 550m; vcmo = 550m; m = 2; C_load = 300f; Ln_tail = 65n; Wn_idc = 8.3u; Wn_in = 55u; Wn_tail = 90u
  Temperature: 27
  Analysis tran: stop=400n
  Analysis dc: (saves the operating point)
  Output (VT("/vop") - VT("/von"))
  Output VT("/a0")
  Output VT("/a1b")
  Output VT("/p2b")
  Output VT("/p2")
  Output VT("/a1")
  Output VT("/dac_outn") (unticked)
  Output VT("/dac_outp") (unticked)
  Output VT("/von")
  Output VT("/vinp_amp") (unticked)
  Output VT("/vinn_amp") (unticked)
  Output VT("/vop")
  Output (VT("/vinp") - VT("/vinn"))
  Output ((VT("/vop") + VT("/von")) / 2)
  Output VT("/p1e")
  Output VT("/p1eb")
  Signals: /vinp, /p2, /vinn_amp, /vinp_amp, /von, /vop, /dac_outn, /dac_outp, /a1b, /a1, /vinn, /p1e, /p1eb
Run mode: Single Run, Sweeps and Corners
