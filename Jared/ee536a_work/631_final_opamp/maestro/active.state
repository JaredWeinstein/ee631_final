ADE simulation setup
Test ee536a_work_631_final_opamp_1: ee536a_work/631_final_opamp/schematic, simulator spectre
  Models: /home/jaredwei@vlab.usc.edu/ee536a/Techfile_45nm.scs
  Variables: Lp_tail = 135n; Wp_tail = 1u; C_load = 100f; fin = 100M; Ln_l = 90n; Ln_s = 90n; Lp_l = 135n; Lp_s = 90n; vb1 = 0.5; vb2 = 0.2; vb3 = 0.65; vb4 = 0.5; vcm = 0.12; Wn_12 = 800n; Wn_34 = 1.2u; Wp_12 = 800n; Wp_34 = 3u; Wp_56 = 2.5u; Wp_78 = 45u; Wp_9 = 7u
  Temperature: 27
  Analysis ac: start=1K stop=1G
  Analysis dc: (saves the operating point)
  Output (VF("/vinp") - VF("/vinn")) (unticked)
  Output (VF("/voutp") - VF("/voutn")) (unticked)
  Output db20((VF("/voutp") - VF("/voutn")))
  Output phase((VF("/voutp") - VF("/voutn")))
  Signals: /vinp, /vinn, /voutp, /voutn
Run mode: Single Run, Sweeps and Corners
