ADE simulation setup
Run mode: Single Run, Sweeps and Corners
Tests:
  custom_cells_NOR2_1X_1: custom_cells/NOR2_1X/schematic, simulator spectre
