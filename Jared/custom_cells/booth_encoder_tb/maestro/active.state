ADE simulation setup
Test EE477_booth_encoder_tb_1: EE477/booth_encoder_tb/config, simulator spectre
  Models: /home/viterbi/01/ee577/CDS_GPDK45/gpdk045_v_5_0/gpdk045/../models/spectre/gpdk045.scs[mc]
  Temperature: 27
  Files: vectors /home/viterbi/03/jryao/work_gpdk045/booth_encoder_test.vec
  Stimulus vdd!: voltage dc dc=1
  Analysis tran: stop=10n errpreset=conservative
  Signals: /y_7, /y_6, /y_5, /y_4, /y_3, /y_2, /y_1, /y_0, /x_2, /x_1, /x_0, /o8, /o7, /o6, /o5, /o4, /o3, /o2, /o1, /o0
