ADE simulation setup
Test custom_cells_MUX2_1X_1: custom_cells/MUX2_1X/schematic, simulator spectre
  Models: /home/viterbi/01/ee577/CDS_GPDK45/gpdk045_v_5_0/gpdk045/../models/spectre/gpdk045.scs[mc]
  Temperature: 27
  Stimulus S: voltage bit rise=10ps fall=10ps period=1ns data=01
  Stimulus A: voltage bit rise=10ps fall=10ps period=1ns data=00
  Stimulus B: voltage bit rise=10ps fall=10ps period=1ns data=11
  Stimulus vdd!: voltage dc dc=1
  Analysis tran: stop=10n
  Signals: /A, /B, /S, /out
