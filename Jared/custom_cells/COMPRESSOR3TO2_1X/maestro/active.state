ADE simulation setup
Test custom_cells_COMPRESSOR3TO2_1X_1: custom_cells/COMPRESSOR3TO2_1X/schematic, simulator spectre
  Models: /home/viterbi/01/ee577/CDS_GPDK45/gpdk045_v_5_0/gpdk045/../models/spectre/gpdk045.scs[mc]
  Temperature: 27
  Files: vectors /home/viterbi/02/jjmoya/simulation/phase2_final_project_ee477.vec
  Analysis tran: stop=10n
  Signals: /X, /Y, /Z, /C, /S
Run mode: Single Run, Sweeps and Corners
