ADE simulation setup
Run mode: Single Run, Sweeps and Corners
Tests:
  custom_cells_COMPRESSOR3TO2_1X_1: custom_cells/COMPRESSOR3TO2_1X/schematic, simulator spectre
