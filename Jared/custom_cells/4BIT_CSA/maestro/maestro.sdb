ADE simulation setup
Run mode: Single Run, Sweeps and Corners
Tests:
  custom_cells_4BIT_CSA_1: custom_cells/4BIT_CSA/schematic, simulator spectre
