ADE simulation setup
Test custom_cells_dff_1: custom_cells/dff/schematic, simulator spectre
  Models: /home/jjmoya@vlab.usc.edu/ee536a/Techfile_45nm.scs
  Variables: Lndff = 45n; Lpdff = 45n; Wndff = 45n; Wpdff = 90n
  Temperature: 27
  Stimulus D: voltage bit val1=1.1 rise=10p fall=10p period=3n srcType=bit data=0101010101
  Stimulus CLK: voltage bit val1=1.1 rise=10p fall=10p period=1n srcType=bit data=0101010101
  Stimulus vdd!: voltage dc dc=1.1 srcType=dc
  Analysis tran: stop=10n
  Signals: /D, /CLK, /Q, /I11/in (terminal), /I11/out (terminal)
Run mode: Single Run, Sweeps and Corners
