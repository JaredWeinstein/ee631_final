ADE simulation setup
Run mode: Single Run, Sweeps and Corners
Tests:
  custom_cells_dff_1: custom_cells/dff/schematic, simulator spectre
    Variables: Lndff = 45n; Lpdff = 45n; Wndff = 45n; Wpdff = 90n
