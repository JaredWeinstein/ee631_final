ADE simulation setup
Test custom_cells_DFF_1x_1: custom_cells/DFF_1x/schematic, simulator spectre
  Models: /home/jjmoya@vlab.usc.edu/ee536a/Techfile_45nm.scs
  Variables: Lndff = 45n; Lpdff = 45n; Wndff = 90n; Wpdff = 90n
  Temperature: 27
  Stimulus D: voltage bit val1=1.1 rise=10p fall=10p period=3n srcType=bit data=0101010101
  Stimulus CLK: voltage bit val1=1.1 rise=10p fall=10p period=1n srcType=bit data=0101010101
  Analysis tran: stop=10n
  Signals: /Q, /CLK, /D
