ADE simulation setup
Test custom_cells_XOR2_1X_1: custom_cells/XOR2_1X/schematic, simulator spectre
  Models: /home/viterbi/01/ee577/CDS_GPDK45/gpdk045_v_5_0/gpdk045/../models/spectre/gpdk045.scs[mc]
  Temperature: 27
  Stimulus vdd!: voltage dc dc=1
  Stimulus a: voltage bit rise=10p fall=10p period=1n data=0101
  Stimulus b: voltage bit rise=10p fall=10p period=1n data=0011
  Analysis tran: stop=10n
  Signals: /a, /b, /out
