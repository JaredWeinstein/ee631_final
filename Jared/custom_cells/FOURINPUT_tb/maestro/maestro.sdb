ADE simulation setup
Run mode: Single Run, Sweeps and Corners
Tests:
  custom_cells_FOURINPUT_tb_1: custom_cells/FOURINPUT_tb/schematic, simulator spectre
