ADE simulation setup
Run mode: Single Run, Sweeps and Corners
Tests:
  INV_1X_INV_1X_1: custom_cells/INV/schematic, simulator spectre
