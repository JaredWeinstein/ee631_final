ADE simulation setup
Test custom_cells_8BIT_CSA_1: custom_cells/8BIT_CSA/schematic, simulator spectre
  Models: /home/viterbi/01/ee577/CDS_GPDK45/gpdk045_v_5_0/gpdk045/../models/spectre/gpdk045.scs[mc]
  Temperature: 27
  Files: vectors /home/viterbi/02/jjmoya/work_gpdk045/sim_files/file_simple_8-bit.vec
  Analysis tran: stop=10n
  Signals: /cin, /B0, /B1, /B2, /B3, /B4, /B5, /B6, /B7, /A0, /A1, /A2, /A3, /A4, /A5, /A6, /A7, /Cout, /S0, /S1, /S2, /S3, /s4, /s5, /s6, /s7
Run mode: Single Run, Sweeps and Corners
