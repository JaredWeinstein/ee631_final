ADE simulation setup
Run mode: Single Run, Sweeps and Corners
Tests:
  custom_cells_8BIT_CSA_1: custom_cells/8BIT_CSA/schematic, simulator spectre
