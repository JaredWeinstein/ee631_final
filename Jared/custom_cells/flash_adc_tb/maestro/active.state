ADE simulation setup
Test ee631_project_flash_adc_tb_1: ee631_project/flash_adc_tb/schematic, simulator spectre
  Models: /home/jjmoya@vlab.usc.edu/ee536a/Techfile_45nm.scs
  Variables: L = 45n; W = 10u; fclk = 1G; madc = 100p
  Temperature: 27
  Stimulus vin: voltage pulse val0=300.0m val1=800.0m period=20n rise=20n srcType=pulse
  Analysis tran: stop=20n
  Signals: /vin, /OUT, /net4 as a0, /net3 as a0b, /net2 as a1, /net1 as a1b
