ADE simulation setup
Test custom_cells_TWOINPUT_tb_1: custom_cells/TWOINPUT_tb/config, simulator spectre
  Models: /home/viterbi/01/ee577/CDS_GPDK45/gpdk045_v_5_0/gpdk045/../models/spectre/gpdk045.scs[mc]
  Temperature: 27
  Stimulus vdd!: voltage dc dc=1
  Stimulus in_a: voltage bit rise=10p fall=10p period=1n data=01000
  Stimulus in_b: voltage bit rise=10p fall=10p period=1n data=00010
  Analysis tran: stop=10n
  Signals: /ina, /inb, /out
