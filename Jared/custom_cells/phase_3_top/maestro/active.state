ADE simulation setup
Test custom_cells_phase_3_top_1: custom_cells/phase_3_top/schematic, simulator spectre
  Models: /home/viterbi/01/ee577/CDS_GPDK45/gpdk045_v_5_0/gpdk045/../models/spectre/gpdk045.scs[mc]
  Temperature: 27
  Files: vectors /home/viterbi/02/jjmoya/simulation/16bit_MAC_tb.vec
  Stimulus vdd!: voltage dc dc=1
  Analysis tran: stop=22n
  Signals: /a0, /a1, /a2, /a3, /a4, /a6, /a5, /a7, /b0, /b1, /b2, /b3, /b5, /b4, /b6, /b7, /Q0, /Q1, /Q2, /Q3, /Q4, /Q5, /Q6, /Q7, /Q8, /Q9, /Q10, /Q11, /Q12, /Q13, /Q14, /Q15
Run mode: Single Run, Sweeps and Corners
