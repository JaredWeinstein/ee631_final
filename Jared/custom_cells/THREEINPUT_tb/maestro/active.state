ADE simulation setup
Test custom_cells_THREEINPUT_tb_1: custom_cells/THREEINPUT_tb/config, simulator spectre
  Models: /home/viterbi/01/ee577/CDS_GPDK45/gpdk045_v_5_0/gpdk045/../models/spectre/gpdk045.scs[mc]
  Temperature: 27
  Stimulus A: voltage bit rise=10ps fall=10ps period=1ns data=00
  Stimulus B: voltage bit rise=10ps fall=10ps period=1ns data=11
  Stimulus Cin: voltage bit rise=10ps fall=10ps period=1ns data=10
  Stimulus vdd!: voltage dc dc=1
  Analysis tran: stop=10n
  Signals: /cin, /b, /a, /S, /Cout
