ADE simulation setup
Run mode: Single Run, Sweeps and Corners
Tests:
  ee536a_work_631_comparator_1: ee536a_work/631_comparator/schematic, simulator spectre
    Variables: f_in = 102.4M; fclk = 1G; Ln = 45n; Lp = 45n; vcm = 0.6; W_12 = 300n; W_34 = 150n; W_56 = 150n; W_switch = 150n; C_out = 15f; W_tail = 1u; L_inv = 45n; W_inv = 150n; W_invp = 200n
    Outputs: (VT("/vin1") - VT("/vin2")); VT("/voutp"); VT("/vin2"); VT("/vin1"); VT("/voutn"); VT("/net3")
