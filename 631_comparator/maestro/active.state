ADE simulation setup
Test ee536a_work_631_comparator_1: ee536a_work/631_comparator/schematic, simulator spectre
  Models: /home/jaredwei@vlab.usc.edu/ee536a/Techfile_45nm.scs
  Variables: L_inv = 45n; W_inv = 150n; W_invp = 200n; f_in = 102.4M; fclk = 1G; Ln = 45n; Lp = 45n; vcm = 0.6; W_12 = 300n; W_34 = 150n; W_56 = 150n; W_switch = 150n; C_out = 15f; W_tail = 1u
  Temperature: 27
  Analysis dc: (saves the operating point)
  Analysis ac: start=1K stop=10G
  Output VT("/clk") (unticked)
  Output (VT("/vin1") - VT("/vin2"))
  Output (VT("/voutp") - VT("/voutn")) (unticked)
  Output VT("/voutp")
  Output VT("/voutn")
  Output VT("/net3") (unticked)
  Output VF("/voutp")
  Signals: /clk, /vin1, /vin2, /voutp, /voutn, /net3
Run mode: Single Run, Sweeps and Corners
